// Copyright 2018-2021 ETH Zurich and University of Bologna.
// Solderpad Hardware License, Version 0.51, see LICENSE for details.
// SPDX-License-Identifier: SHL-0.51
//
// Authors: 
// Nicole Narr <narrn@ethz.ch>
// Christopher Reinwardt <creinwar@ethz.ch>



{
  name: "axi_llc",
  clock_primary: "clk_i",
  bus_interfaces: [
    { protocol: "reg_iface", direction: "device" }
  ],
  regwidth: 32,
  registers: [

    { name: "CFG_SPM_LOW",
      desc: "SPM Configuration (lower 32 bit)",
      swaccess: "rw",
      hwaccess: "hrw",
      fields: [
        {bits: "31:0", resval: 0, name: "low", desc: "lower 32 bit"}
      ]
    },
    { name: "CFG_SPM_HIGH",
      desc: "SPM Configuration (upper 32 bit)",
      swaccess: "rw",
      hwaccess: "hrw",
      fields: [
        {bits: "31:0", name: "high", desc: "upper 32 bit"}
      ]
    },
    { name: "CFG_FLUSH_LOW",
      desc: "Flush Configuration (lower 32 bit)",
      swaccess: "rw",
      hwaccess: "hrw",
      fields: [
        {bits: "31:0", name: "low", desc: "lower 32 bit"}
      ]
    },
    { name: "CFG_FLUSH_HIGH",
      desc: "Flush Configuration (upper 32 bit)",
      swaccess: "rw",
      hwaccess: "hrw",
      fields: [
        {bits: "31:0", name: "high", desc: "upper 32 bit"}
      ]
    },
    { name: "CFG_FLUSH_SET0_LOW",
      desc: "Index-based Flush Configuration [31:0] (lower 32 bit)",
      swaccess: "rw",
      hwaccess: "hrw",
      fields: [
        {bits: "31:0", name: "low", desc: "lower 32 bit"}
      ]
    },
    { name: "CFG_FLUSH_SET0_HIGH",
      desc: "Index-based Flush Configuration [63:32] (upper 32 bit)",
      swaccess: "rw",
      hwaccess: "hrw",
      fields: [
        {bits: "31:0", name: "high", desc: "upper 32 bit"}
      ]
    },
    { name: "CFG_FLUSH_SET1_LOW",
      desc: "Index-based Flush Configuration [95:64] (lower 32 bit)",
      swaccess: "rw",
      hwaccess: "hrw",
      fields: [
        {bits: "31:0", name: "low", desc: "lower 32 bit"}
      ]
    },
    { name: "CFG_FLUSH_SET1_HIGH",
      desc: "Index-based Flush Configuration [127:96] (upper 32 bit)",
      swaccess: "rw",
      hwaccess: "hrw",
      fields: [
        {bits: "31:0", name: "high", desc: "upper 32 bit"}
      ]
    },
    { name: "CFG_FLUSH_SET2_LOW",
      desc: "Index-based Flush Configuration [159:128] (lower 32 bit)",
      swaccess: "rw",
      hwaccess: "hrw",
      fields: [
        {bits: "31:0", name: "low", desc: "lower 32 bit"}
      ]
    },
    { name: "CFG_FLUSH_SET2_HIGH",
      desc: "Index-based Flush Configuration [191:160] (upper 32 bit)",
      swaccess: "rw",
      hwaccess: "hrw",
      fields: [
        {bits: "31:0", name: "high", desc: "upper 32 bit"}
      ]
    },
    { name: "CFG_FLUSH_SET3_LOW",
      desc: "Index-based Flush Configuration [223:192] (lower 32 bit)",
      swaccess: "rw",
      hwaccess: "hrw",
      fields: [
        {bits: "31:0", name: "low", desc: "lower 32 bit"}
      ]
    },
    { name: "CFG_FLUSH_SET3_HIGH",
      desc: "Index-based Flush Configuration [255:224] (upper 32 bit)",
      swaccess: "rw",
      hwaccess: "hrw",
      fields: [
        {bits: "31:0", name: "high", desc: "upper 32 bit"}
      ]
    },
    { name: "CFG_FLUSH_SET4_LOW",
      desc: "Index-based Flush Configuration [287:256] (lower 32 bit)",
      swaccess: "rw",
      hwaccess: "hrw",
      fields: [
        {bits: "31:0", name: "low", desc: "lower 32 bit"}
      ]
    },
    { name: "CFG_FLUSH_SET4_HIGH",
      desc: "Index-based Flush Configuration [319:288] (upper 32 bit)",
      swaccess: "rw",
      hwaccess: "hrw",
      fields: [
        {bits: "31:0", name: "high", desc: "upper 32 bit"}
      ]
    },
    { name: "CFG_FLUSH_SET5_LOW",
      desc: "Index-based Flush Configuration [351:320] (lower 32 bit)",
      swaccess: "rw",
      hwaccess: "hrw",
      fields: [
        {bits: "31:0", name: "low", desc: "lower 32 bit"}
      ]
    },
    { name: "CFG_FLUSH_SET5_HIGH",
      desc: "Index-based Flush Configuration [383:352] (upper 32 bit)",
      swaccess: "rw",
      hwaccess: "hrw",
      fields: [
        {bits: "31:0", name: "high", desc: "upper 32 bit"}
      ]
    },
    { name: "CFG_FLUSH_SET6_LOW",
      desc: "Index-based Flush Configuration [415:384] (lower 32 bit)",
      swaccess: "rw",
      hwaccess: "hrw",
      fields: [
        {bits: "31:0", name: "low", desc: "lower 32 bit"}
      ]
    },
    { name: "CFG_FLUSH_SET6_HIGH",
      desc: "Index-based Flush Configuration [447:416] (upper 32 bit)",
      swaccess: "rw",
      hwaccess: "hrw",
      fields: [
        {bits: "31:0", name: "high", desc: "upper 32 bit"}
      ]
    },
    { name: "CFG_FLUSH_SET7_LOW",
      desc: "Index-based Flush Configuration [479:448] (lower 32 bit)",
      swaccess: "rw",
      hwaccess: "hrw",
      fields: [
        {bits: "31:0", name: "low", desc: "lower 32 bit"}
      ]
    },
    { name: "CFG_FLUSH_SET7_HIGH",
      desc: "Index-based Flush Configuration [511:480] (upper 32 bit)",
      swaccess: "rw",
      hwaccess: "hrw",
      fields: [
        {bits: "31:0", name: "high", desc: "upper 32 bit"}
      ]
    },
    { name: "CFG_SET_PARTITION0_LOW",
       desc: "Index-based Partition Configuration [31:0] (lower 32 bit)",
       swaccess: "rw",
       hwaccess: "hrw",
       fields: [
        {bits: "31:0", name: "low", desc: "lower 32 bit"}
       ]
    },
    { name: "CFG_SET_PARTITION0_HIGH",
       desc: "Index-based Partition Configuration [63:32] (upper 32 bit)",
       swaccess: "rw",
       hwaccess: "hrw",
       fields: [
        {bits: "31:0", name: "high", desc: "upper 32 bit"}
       ]
    },
    { name: "CFG_SET_PARTITION1_LOW",
       desc: "Index-based Partition Configuration [31:0] (lower 32 bit)",
       swaccess: "rw",
       hwaccess: "hrw",
       fields: [
        {bits: "31:0", name: "low", desc: "lower 32 bit"}
       ]
    },
    { name: "CFG_SET_PARTITION1_HIGH",
       desc: "Index-based Partition Configuration [63:32] (upper 32 bit)",
       swaccess: "rw",
       hwaccess: "hrw",
       fields: [
        {bits: "31:0", name: "high", desc: "upper 32 bit"}
       ]
    },
    { name: "CFG_SET_PARTITION2_LOW",
       desc: "Index-based Partition Configuration [31:0] (lower 32 bit)",
       swaccess: "rw",
       hwaccess: "hrw",
       fields: [
        {bits: "31:0", name: "low", desc: "lower 32 bit"}
       ]
    },
    { name: "CFG_SET_PARTITION2_HIGH",
       desc: "Index-based Partition Configuration [63:32] (upper 32 bit)",
       swaccess: "rw",
       hwaccess: "hrw",
       fields: [
        {bits: "31:0", name: "high", desc: "upper 32 bit"}
       ]
    },
    { name: "CFG_SET_PARTITION3_LOW",
       desc: "Index-based Partition Configuration [31:0] (lower 32 bit)",
       swaccess: "rw",
       hwaccess: "hrw",
       fields: [
        {bits: "31:0", name: "low", desc: "lower 32 bit"}
       ]
    },
    { name: "CFG_SET_PARTITION3_HIGH",
       desc: "Index-based Partition Configuration [63:32] (upper 32 bit)",
       swaccess: "rw",
       hwaccess: "hrw",
       fields: [
        {bits: "31:0", name: "high", desc: "upper 32 bit"}
       ]
    },
    { name: "CFG_SET_PARTITION4_LOW",
       desc: "Index-based Partition Configuration [31:0] (lower 32 bit)",
       swaccess: "rw",
       hwaccess: "hrw",
       fields: [
        {bits: "31:0", name: "low", desc: "lower 32 bit"}
       ]
    },
    { name: "CFG_SET_PARTITION4_HIGH",
       desc: "Index-based Partition Configuration [63:32] (upper 32 bit)",
       swaccess: "rw",
       hwaccess: "hrw",
       fields: [
        {bits: "31:0", name: "high", desc: "upper 32 bit"}
       ]
    },
    { name: "CFG_SET_PARTITION5_LOW",
       desc: "Index-based Partition Configuration [31:0] (lower 32 bit)",
       swaccess: "rw",
       hwaccess: "hrw",
       fields: [
        {bits: "31:0", name: "low", desc: "lower 32 bit"}
       ]
    },
    { name: "CFG_SET_PARTITION5_HIGH",
       desc: "Index-based Partition Configuration [63:32] (upper 32 bit)",
       swaccess: "rw",
       hwaccess: "hrw",
       fields: [
        {bits: "31:0", name: "high", desc: "upper 32 bit"}
       ]
    },
    { name: "CFG_SET_PARTITION6_LOW",
       desc: "Index-based Partition Configuration [31:0] (lower 32 bit)",
       swaccess: "rw",
       hwaccess: "hrw",
       fields: [
        {bits: "31:0", name: "low", desc: "lower 32 bit"}
       ]
    },
    { name: "CFG_SET_PARTITION6_HIGH",
       desc: "Index-based Partition Configuration [63:32] (upper 32 bit)",
       swaccess: "rw",
       hwaccess: "hrw",
       fields: [
        {bits: "31:0", name: "high", desc: "upper 32 bit"}
       ]
    },
    { name: "CFG_SET_PARTITION7_LOW",
       desc: "Index-based Partition Configuration [31:0] (lower 32 bit)",
       swaccess: "rw",
       hwaccess: "hrw",
       fields: [
        {bits: "31:0", name: "low", desc: "lower 32 bit"}
       ]
    },
    { name: "CFG_SET_PARTITION7_HIGH",
       desc: "Index-based Partition Configuration [63:32] (upper 32 bit)",
       swaccess: "rw",
       hwaccess: "hrw",
       fields: [
        {bits: "31:0", name: "high", desc: "upper 32 bit"}
       ]
    },
    { name: "CFG_SET_PARTITION8_LOW",
       desc: "Index-based Partition Configuration [31:0] (lower 32 bit)",
       swaccess: "rw",
       hwaccess: "hrw",
       fields: [
        {bits: "31:0", name: "low", desc: "lower 32 bit"}
       ]
    },
    { name: "CFG_SET_PARTITION8_HIGH",
       desc: "Index-based Partition Configuration [63:32] (upper 32 bit)",
       swaccess: "rw",
       hwaccess: "hrw",
       fields: [
        {bits: "31:0", name: "high", desc: "upper 32 bit"}
       ]
    },
    { name: "CFG_SET_PARTITION9_LOW",
       desc: "Index-based Partition Configuration [31:0] (lower 32 bit)",
       swaccess: "rw",
       hwaccess: "hrw",
       fields: [
        {bits: "31:0", name: "low", desc: "lower 32 bit"}
       ]
    },
    { name: "CFG_SET_PARTITION9_HIGH",
       desc: "Index-based Partition Configuration [63:32] (upper 32 bit)",
       swaccess: "rw",
       hwaccess: "hrw",
       fields: [
        {bits: "31:0", name: "high", desc: "upper 32 bit"}
       ]
    },
    { name: "CFG_SET_PARTITION10_LOW",
       desc: "Index-based Partition Configuration [31:0] (lower 32 bit)",
       swaccess: "rw",
       hwaccess: "hrw",
       fields: [
        {bits: "31:0", name: "low", desc: "lower 32 bit"}
       ]
    },
    { name: "CFG_SET_PARTITION10_HIGH",
       desc: "Index-based Partition Configuration [63:32] (upper 32 bit)",
       swaccess: "rw",
       hwaccess: "hrw",
       fields: [
        {bits: "31:0", name: "high", desc: "upper 32 bit"}
       ]
    },
    { name: "CFG_SET_PARTITION11_LOW",
       desc: "Index-based Partition Configuration [31:0] (lower 32 bit)",
       swaccess: "rw",
       hwaccess: "hrw",
       fields: [
        {bits: "31:0", name: "low", desc: "lower 32 bit"}
       ]
    },
    { name: "CFG_SET_PARTITION11_HIGH",
       desc: "Index-based Partition Configuration [63:32] (upper 32 bit)",
       swaccess: "rw",
       hwaccess: "hrw",
       fields: [
        {bits: "31:0", name: "high", desc: "upper 32 bit"}
       ]
    },
    { name: "CFG_SET_PARTITION12_LOW",
       desc: "Index-based Partition Configuration [31:0] (lower 32 bit)",
       swaccess: "rw",
       hwaccess: "hrw",
       fields: [
        {bits: "31:0", name: "low", desc: "lower 32 bit"}
       ]
    },
    { name: "CFG_SET_PARTITION12_HIGH",
       desc: "Index-based Partition Configuration [63:32] (upper 32 bit)",
       swaccess: "rw",
       hwaccess: "hrw",
       fields: [
        {bits: "31:0", name: "high", desc: "upper 32 bit"}
       ]
    },
    { name: "CFG_SET_PARTITION13_LOW",
       desc: "Index-based Partition Configuration [31:0] (lower 32 bit)",
       swaccess: "rw",
       hwaccess: "hrw",
       fields: [
        {bits: "31:0", name: "low", desc: "lower 32 bit"}
       ]
    },
    { name: "CFG_SET_PARTITION13_HIGH",
       desc: "Index-based Partition Configuration [63:32] (upper 32 bit)",
       swaccess: "rw",
       hwaccess: "hrw",
       fields: [
        {bits: "31:0", name: "high", desc: "upper 32 bit"}
       ]
    },
    { name: "CFG_SET_PARTITION14_LOW",
       desc: "Index-based Partition Configuration [31:0] (lower 32 bit)",
       swaccess: "rw",
       hwaccess: "hrw",
       fields: [
        {bits: "31:0", name: "low", desc: "lower 32 bit"}
       ]
    },
    { name: "CFG_SET_PARTITION14_HIGH",
       desc: "Index-based Partition Configuration [63:32] (upper 32 bit)",
       swaccess: "rw",
       hwaccess: "hrw",
       fields: [
        {bits: "31:0", name: "high", desc: "upper 32 bit"}
       ]
    },
    { name: "CFG_SET_PARTITION15_LOW",
       desc: "Index-based Partition Configuration [31:0] (lower 32 bit)",
       swaccess: "rw",
       hwaccess: "hrw",
       fields: [
        {bits: "31:0", name: "low", desc: "lower 32 bit"}
       ]
    },
    { name: "CFG_SET_PARTITION15_HIGH",
       desc: "Index-based Partition Configuration [63:32] (upper 32 bit)",
       swaccess: "rw",
       hwaccess: "hrw",
       fields: [
        {bits: "31:0", name: "high", desc: "upper 32 bit"}
       ]
    },
    { name: "CFG_SET_PARTITION16_LOW",
       desc: "Index-based Partition Configuration [31:0] (lower 32 bit)",
       swaccess: "rw",
       hwaccess: "hrw",
       fields: [
        {bits: "31:0", name: "low", desc: "lower 32 bit"}
       ]
    },
    { name: "CFG_SET_PARTITION16_HIGH",
       desc: "Index-based Partition Configuration [63:32] (upper 32 bit)",
       swaccess: "rw",
       hwaccess: "hrw",
       fields: [
        {bits: "31:0", name: "high", desc: "upper 32 bit"}
       ]
    },
    { name: "CFG_SET_PARTITION17_LOW",
       desc: "Index-based Partition Configuration [31:0] (lower 32 bit)",
       swaccess: "rw",
       hwaccess: "hrw",
       fields: [
        {bits: "31:0", name: "low", desc: "lower 32 bit"}
       ]
    },
    { name: "CFG_SET_PARTITION17_HIGH",
       desc: "Index-based Partition Configuration [63:32] (upper 32 bit)",
       swaccess: "rw",
       hwaccess: "hrw",
       fields: [
        {bits: "31:0", name: "high", desc: "upper 32 bit"}
       ]
    },
    { name: "CFG_SET_PARTITION18_LOW",
       desc: "Index-based Partition Configuration [31:0] (lower 32 bit)",
       swaccess: "rw",
       hwaccess: "hrw",
       fields: [
        {bits: "31:0", name: "low", desc: "lower 32 bit"}
       ]
    },
    { name: "CFG_SET_PARTITION18_HIGH",
       desc: "Index-based Partition Configuration [63:32] (upper 32 bit)",
       swaccess: "rw",
       hwaccess: "hrw",
       fields: [
        {bits: "31:0", name: "high", desc: "upper 32 bit"}
       ]
    },
    { name: "CFG_SET_PARTITION19_LOW",
       desc: "Index-based Partition Configuration [31:0] (lower 32 bit)",
       swaccess: "rw",
       hwaccess: "hrw",
       fields: [
        {bits: "31:0", name: "low", desc: "lower 32 bit"}
       ]
    },
    { name: "CFG_SET_PARTITION19_HIGH",
       desc: "Index-based Partition Configuration [63:32] (upper 32 bit)",
       swaccess: "rw",
       hwaccess: "hrw",
       fields: [
        {bits: "31:0", name: "high", desc: "upper 32 bit"}
       ]
    },
    { name: "CFG_SET_PARTITION20_LOW",
       desc: "Index-based Partition Configuration [31:0] (lower 32 bit)",
       swaccess: "rw",
       hwaccess: "hrw",
       fields: [
        {bits: "31:0", name: "low", desc: "lower 32 bit"}
       ]
    },
    { name: "CFG_SET_PARTITION20_HIGH",
       desc: "Index-based Partition Configuration [63:32] (upper 32 bit)",
       swaccess: "rw",
       hwaccess: "hrw",
       fields: [
        {bits: "31:0", name: "high", desc: "upper 32 bit"}
       ]
    },
    { name: "CFG_SET_PARTITION21_LOW",
       desc: "Index-based Partition Configuration [31:0] (lower 32 bit)",
       swaccess: "rw",
       hwaccess: "hrw",
       fields: [
        {bits: "31:0", name: "low", desc: "lower 32 bit"}
       ]
    },
    { name: "CFG_SET_PARTITION21_HIGH",
       desc: "Index-based Partition Configuration [63:32] (upper 32 bit)",
       swaccess: "rw",
       hwaccess: "hrw",
       fields: [
        {bits: "31:0", name: "high", desc: "upper 32 bit"}
       ]
    },
    { name: "CFG_SET_PARTITION22_LOW",
       desc: "Index-based Partition Configuration [31:0] (lower 32 bit)",
       swaccess: "rw",
       hwaccess: "hrw",
       fields: [
        {bits: "31:0", name: "low", desc: "lower 32 bit"}
       ]
    },
    { name: "CFG_SET_PARTITION22_HIGH",
       desc: "Index-based Partition Configuration [63:32] (upper 32 bit)",
       swaccess: "rw",
       hwaccess: "hrw",
       fields: [
        {bits: "31:0", name: "high", desc: "upper 32 bit"}
       ]
    },
    { name: "CFG_SET_PARTITION23_LOW",
       desc: "Index-based Partition Configuration [31:0] (lower 32 bit)",
       swaccess: "rw",
       hwaccess: "hrw",
       fields: [
        {bits: "31:0", name: "low", desc: "lower 32 bit"}
       ]
    },
    { name: "CFG_SET_PARTITION23_HIGH",
       desc: "Index-based Partition Configuration [63:32] (upper 32 bit)",
       swaccess: "rw",
       hwaccess: "hrw",
       fields: [
        {bits: "31:0", name: "high", desc: "upper 32 bit"}
       ]
    },
    { name: "CFG_SET_PARTITION24_LOW",
       desc: "Index-based Partition Configuration [31:0] (lower 32 bit)",
       swaccess: "rw",
       hwaccess: "hrw",
       fields: [
        {bits: "31:0", name: "low", desc: "lower 32 bit"}
       ]
    },
    { name: "CFG_SET_PARTITION24_HIGH",
       desc: "Index-based Partition Configuration [63:32] (upper 32 bit)",
       swaccess: "rw",
       hwaccess: "hrw",
       fields: [
        {bits: "31:0", name: "high", desc: "upper 32 bit"}
       ]
    },
    { name: "CFG_SET_PARTITION25_LOW",
       desc: "Index-based Partition Configuration [31:0] (lower 32 bit)",
       swaccess: "rw",
       hwaccess: "hrw",
       fields: [
        {bits: "31:0", name: "low", desc: "lower 32 bit"}
       ]
    },
    { name: "CFG_SET_PARTITION25_HIGH",
       desc: "Index-based Partition Configuration [63:32] (upper 32 bit)",
       swaccess: "rw",
       hwaccess: "hrw",
       fields: [
        {bits: "31:0", name: "high", desc: "upper 32 bit"}
       ]
    },
    { name: "CFG_SET_PARTITION26_LOW",
       desc: "Index-based Partition Configuration [31:0] (lower 32 bit)",
       swaccess: "rw",
       hwaccess: "hrw",
       fields: [
        {bits: "31:0", name: "low", desc: "lower 32 bit"}
       ]
    },
    { name: "CFG_SET_PARTITION26_HIGH",
       desc: "Index-based Partition Configuration [63:32] (upper 32 bit)",
       swaccess: "rw",
       hwaccess: "hrw",
       fields: [
        {bits: "31:0", name: "high", desc: "upper 32 bit"}
       ]
    },
    { name: "CFG_SET_PARTITION27_LOW",
       desc: "Index-based Partition Configuration [31:0] (lower 32 bit)",
       swaccess: "rw",
       hwaccess: "hrw",
       fields: [
        {bits: "31:0", name: "low", desc: "lower 32 bit"}
       ]
    },
    { name: "CFG_SET_PARTITION27_HIGH",
       desc: "Index-based Partition Configuration [63:32] (upper 32 bit)",
       swaccess: "rw",
       hwaccess: "hrw",
       fields: [
        {bits: "31:0", name: "high", desc: "upper 32 bit"}
       ]
    },
    { name: "CFG_SET_PARTITION28_LOW",
       desc: "Index-based Partition Configuration [31:0] (lower 32 bit)",
       swaccess: "rw",
       hwaccess: "hrw",
       fields: [
        {bits: "31:0", name: "low", desc: "lower 32 bit"}
       ]
    },
    { name: "CFG_SET_PARTITION28_HIGH",
       desc: "Index-based Partition Configuration [63:32] (upper 32 bit)",
       swaccess: "rw",
       hwaccess: "hrw",
       fields: [
        {bits: "31:0", name: "high", desc: "upper 32 bit"}
       ]
    },
    { name: "CFG_SET_PARTITION29_LOW",
       desc: "Index-based Partition Configuration [31:0] (lower 32 bit)",
       swaccess: "rw",
       hwaccess: "hrw",
       fields: [
        {bits: "31:0", name: "low", desc: "lower 32 bit"}
       ]
    },
    { name: "CFG_SET_PARTITION29_HIGH",
       desc: "Index-based Partition Configuration [63:32] (upper 32 bit)",
       swaccess: "rw",
       hwaccess: "hrw",
       fields: [
        {bits: "31:0", name: "high", desc: "upper 32 bit"}
       ]
    },
    { name: "CFG_SET_PARTITION30_LOW",
       desc: "Index-based Partition Configuration [31:0] (lower 32 bit)",
       swaccess: "rw",
       hwaccess: "hrw",
       fields: [
        {bits: "31:0", name: "low", desc: "lower 32 bit"}
       ]
    },
    { name: "CFG_SET_PARTITION30_HIGH",
       desc: "Index-based Partition Configuration [63:32] (upper 32 bit)",
       swaccess: "rw",
       hwaccess: "hrw",
       fields: [
        {bits: "31:0", name: "high", desc: "upper 32 bit"}
       ]
    },
    { name: "CFG_SET_PARTITION31_LOW",
       desc: "Index-based Partition Configuration [31:0] (lower 32 bit)",
       swaccess: "rw",
       hwaccess: "hrw",
       fields: [
        {bits: "31:0", name: "low", desc: "lower 32 bit"}
       ]
    },
    { name: "CFG_SET_PARTITION31_HIGH",
       desc: "Index-based Partition Configuration [63:32] (upper 32 bit)",
       swaccess: "rw",
       hwaccess: "hrw",
       fields: [
        {bits: "31:0", name: "high", desc: "upper 32 bit"}
       ]
    },
    { name: "CFG_SET_PARTITION32_LOW",
       desc: "Index-based Partition Configuration [31:0] (lower 32 bit)",
       swaccess: "rw",
       hwaccess: "hrw",
       fields: [
        {bits: "31:0", name: "low", desc: "lower 32 bit"}
       ]
    },
    { name: "CFG_SET_PARTITION32_HIGH",
       desc: "Index-based Partition Configuration [63:32] (upper 32 bit)",
       swaccess: "rw",
       hwaccess: "hrw",
       fields: [
        {bits: "31:0", name: "high", desc: "upper 32 bit"}
       ]
    },
    { name: "CFG_SET_PARTITION33_LOW",
       desc: "Index-based Partition Configuration [31:0] (lower 32 bit)",
       swaccess: "rw",
       hwaccess: "hrw",
       fields: [
        {bits: "31:0", name: "low", desc: "lower 32 bit"}
       ]
    },
    { name: "CFG_SET_PARTITION33_HIGH",
       desc: "Index-based Partition Configuration [63:32] (upper 32 bit)",
       swaccess: "rw",
       hwaccess: "hrw",
       fields: [
        {bits: "31:0", name: "high", desc: "upper 32 bit"}
       ]
    },
    { name: "CFG_SET_PARTITION34_LOW",
       desc: "Index-based Partition Configuration [31:0] (lower 32 bit)",
       swaccess: "rw",
       hwaccess: "hrw",
       fields: [
        {bits: "31:0", name: "low", desc: "lower 32 bit"}
       ]
    },
    { name: "CFG_SET_PARTITION34_HIGH",
       desc: "Index-based Partition Configuration [63:32] (upper 32 bit)",
       swaccess: "rw",
       hwaccess: "hrw",
       fields: [
        {bits: "31:0", name: "high", desc: "upper 32 bit"}
       ]
    },
    { name: "CFG_SET_PARTITION35_LOW",
       desc: "Index-based Partition Configuration [31:0] (lower 32 bit)",
       swaccess: "rw",
       hwaccess: "hrw",
       fields: [
        {bits: "31:0", name: "low", desc: "lower 32 bit"}
       ]
    },
    { name: "CFG_SET_PARTITION35_HIGH",
       desc: "Index-based Partition Configuration [63:32] (upper 32 bit)",
       swaccess: "rw",
       hwaccess: "hrw",
       fields: [
        {bits: "31:0", name: "high", desc: "upper 32 bit"}
       ]
    },
    { name: "CFG_SET_PARTITION36_LOW",
       desc: "Index-based Partition Configuration [31:0] (lower 32 bit)",
       swaccess: "rw",
       hwaccess: "hrw",
       fields: [
        {bits: "31:0", name: "low", desc: "lower 32 bit"}
       ]
    },
    { name: "CFG_SET_PARTITION36_HIGH",
       desc: "Index-based Partition Configuration [63:32] (upper 32 bit)",
       swaccess: "rw",
       hwaccess: "hrw",
       fields: [
        {bits: "31:0", name: "high", desc: "upper 32 bit"}
       ]
    },
    { name: "CFG_SET_PARTITION37_LOW",
       desc: "Index-based Partition Configuration [31:0] (lower 32 bit)",
       swaccess: "rw",
       hwaccess: "hrw",
       fields: [
        {bits: "31:0", name: "low", desc: "lower 32 bit"}
       ]
    },
    { name: "CFG_SET_PARTITION37_HIGH",
       desc: "Index-based Partition Configuration [63:32] (upper 32 bit)",
       swaccess: "rw",
       hwaccess: "hrw",
       fields: [
        {bits: "31:0", name: "high", desc: "upper 32 bit"}
       ]
    },
    { name: "CFG_SET_PARTITION38_LOW",
       desc: "Index-based Partition Configuration [31:0] (lower 32 bit)",
       swaccess: "rw",
       hwaccess: "hrw",
       fields: [
        {bits: "31:0", name: "low", desc: "lower 32 bit"}
       ]
    },
    { name: "CFG_SET_PARTITION38_HIGH",
       desc: "Index-based Partition Configuration [63:32] (upper 32 bit)",
       swaccess: "rw",
       hwaccess: "hrw",
       fields: [
        {bits: "31:0", name: "high", desc: "upper 32 bit"}
       ]
    },
    { name: "CFG_SET_PARTITION39_LOW",
       desc: "Index-based Partition Configuration [31:0] (lower 32 bit)",
       swaccess: "rw",
       hwaccess: "hrw",
       fields: [
        {bits: "31:0", name: "low", desc: "lower 32 bit"}
       ]
    },
    { name: "CFG_SET_PARTITION39_HIGH",
       desc: "Index-based Partition Configuration [63:32] (upper 32 bit)",
       swaccess: "rw",
       hwaccess: "hrw",
       fields: [
        {bits: "31:0", name: "high", desc: "upper 32 bit"}
       ]
    },
    { name: "CFG_SET_PARTITION40_LOW",
       desc: "Index-based Partition Configuration [31:0] (lower 32 bit)",
       swaccess: "rw",
       hwaccess: "hrw",
       fields: [
        {bits: "31:0", name: "low", desc: "lower 32 bit"}
       ]
    },
    { name: "CFG_SET_PARTITION40_HIGH",
       desc: "Index-based Partition Configuration [63:32] (upper 32 bit)",
       swaccess: "rw",
       hwaccess: "hrw",
       fields: [
        {bits: "31:0", name: "high", desc: "upper 32 bit"}
       ]
    },
    { name: "CFG_SET_PARTITION41_LOW",
       desc: "Index-based Partition Configuration [31:0] (lower 32 bit)",
       swaccess: "rw",
       hwaccess: "hrw",
       fields: [
        {bits: "31:0", name: "low", desc: "lower 32 bit"}
       ]
    },
    { name: "CFG_SET_PARTITION41_HIGH",
       desc: "Index-based Partition Configuration [63:32] (upper 32 bit)",
       swaccess: "rw",
       hwaccess: "hrw",
       fields: [
        {bits: "31:0", name: "high", desc: "upper 32 bit"}
       ]
    },
    { name: "CFG_SET_PARTITION42_LOW",
       desc: "Index-based Partition Configuration [31:0] (lower 32 bit)",
       swaccess: "rw",
       hwaccess: "hrw",
       fields: [
        {bits: "31:0", name: "low", desc: "lower 32 bit"}
       ]
    },
    { name: "CFG_SET_PARTITION42_HIGH",
       desc: "Index-based Partition Configuration [63:32] (upper 32 bit)",
       swaccess: "rw",
       hwaccess: "hrw",
       fields: [
        {bits: "31:0", name: "high", desc: "upper 32 bit"}
       ]
    },
    { name: "CFG_SET_PARTITION43_LOW",
       desc: "Index-based Partition Configuration [31:0] (lower 32 bit)",
       swaccess: "rw",
       hwaccess: "hrw",
       fields: [
        {bits: "31:0", name: "low", desc: "lower 32 bit"}
       ]
    },
    { name: "CFG_SET_PARTITION43_HIGH",
       desc: "Index-based Partition Configuration [63:32] (upper 32 bit)",
       swaccess: "rw",
       hwaccess: "hrw",
       fields: [
        {bits: "31:0", name: "high", desc: "upper 32 bit"}
       ]
    },
    { name: "CFG_SET_PARTITION44_LOW",
       desc: "Index-based Partition Configuration [31:0] (lower 32 bit)",
       swaccess: "rw",
       hwaccess: "hrw",
       fields: [
        {bits: "31:0", name: "low", desc: "lower 32 bit"}
       ]
    },
    { name: "CFG_SET_PARTITION44_HIGH",
       desc: "Index-based Partition Configuration [63:32] (upper 32 bit)",
       swaccess: "rw",
       hwaccess: "hrw",
       fields: [
        {bits: "31:0", name: "high", desc: "upper 32 bit"}
       ]
    },
    { name: "CFG_SET_PARTITION45_LOW",
       desc: "Index-based Partition Configuration [31:0] (lower 32 bit)",
       swaccess: "rw",
       hwaccess: "hrw",
       fields: [
        {bits: "31:0", name: "low", desc: "lower 32 bit"}
       ]
    },
    { name: "CFG_SET_PARTITION45_HIGH",
       desc: "Index-based Partition Configuration [63:32] (upper 32 bit)",
       swaccess: "rw",
       hwaccess: "hrw",
       fields: [
        {bits: "31:0", name: "high", desc: "upper 32 bit"}
       ]
    },
    { name: "CFG_SET_PARTITION46_LOW",
       desc: "Index-based Partition Configuration [31:0] (lower 32 bit)",
       swaccess: "rw",
       hwaccess: "hrw",
       fields: [
        {bits: "31:0", name: "low", desc: "lower 32 bit"}
       ]
    },
    { name: "CFG_SET_PARTITION46_HIGH",
       desc: "Index-based Partition Configuration [63:32] (upper 32 bit)",
       swaccess: "rw",
       hwaccess: "hrw",
       fields: [
        {bits: "31:0", name: "high", desc: "upper 32 bit"}
       ]
    },
    { name: "CFG_SET_PARTITION47_LOW",
       desc: "Index-based Partition Configuration [31:0] (lower 32 bit)",
       swaccess: "rw",
       hwaccess: "hrw",
       fields: [
        {bits: "31:0", name: "low", desc: "lower 32 bit"}
       ]
    },
    { name: "CFG_SET_PARTITION47_HIGH",
       desc: "Index-based Partition Configuration [63:32] (upper 32 bit)",
       swaccess: "rw",
       hwaccess: "hrw",
       fields: [
        {bits: "31:0", name: "high", desc: "upper 32 bit"}
       ]
    },
    { name: "CFG_SET_PARTITION48_LOW",
       desc: "Index-based Partition Configuration [31:0] (lower 32 bit)",
       swaccess: "rw",
       hwaccess: "hrw",
       fields: [
        {bits: "31:0", name: "low", desc: "lower 32 bit"}
       ]
    },
    { name: "CFG_SET_PARTITION48_HIGH",
       desc: "Index-based Partition Configuration [63:32] (upper 32 bit)",
       swaccess: "rw",
       hwaccess: "hrw",
       fields: [
        {bits: "31:0", name: "high", desc: "upper 32 bit"}
       ]
    },
    { name: "CFG_SET_PARTITION49_LOW",
       desc: "Index-based Partition Configuration [31:0] (lower 32 bit)",
       swaccess: "rw",
       hwaccess: "hrw",
       fields: [
        {bits: "31:0", name: "low", desc: "lower 32 bit"}
       ]
    },
    { name: "CFG_SET_PARTITION49_HIGH",
       desc: "Index-based Partition Configuration [63:32] (upper 32 bit)",
       swaccess: "rw",
       hwaccess: "hrw",
       fields: [
        {bits: "31:0", name: "high", desc: "upper 32 bit"}
       ]
    },
    { name: "CFG_SET_PARTITION50_LOW",
       desc: "Index-based Partition Configuration [31:0] (lower 32 bit)",
       swaccess: "rw",
       hwaccess: "hrw",
       fields: [
        {bits: "31:0", name: "low", desc: "lower 32 bit"}
       ]
    },
    { name: "CFG_SET_PARTITION50_HIGH",
       desc: "Index-based Partition Configuration [63:32] (upper 32 bit)",
       swaccess: "rw",
       hwaccess: "hrw",
       fields: [
        {bits: "31:0", name: "high", desc: "upper 32 bit"}
       ]
    },
    { name: "CFG_SET_PARTITION51_LOW",
       desc: "Index-based Partition Configuration [31:0] (lower 32 bit)",
       swaccess: "rw",
       hwaccess: "hrw",
       fields: [
        {bits: "31:0", name: "low", desc: "lower 32 bit"}
       ]
    },
    { name: "CFG_SET_PARTITION51_HIGH",
       desc: "Index-based Partition Configuration [63:32] (upper 32 bit)",
       swaccess: "rw",
       hwaccess: "hrw",
       fields: [
        {bits: "31:0", name: "high", desc: "upper 32 bit"}
       ]
    },
    { name: "CFG_SET_PARTITION52_LOW",
       desc: "Index-based Partition Configuration [31:0] (lower 32 bit)",
       swaccess: "rw",
       hwaccess: "hrw",
       fields: [
        {bits: "31:0", name: "low", desc: "lower 32 bit"}
       ]
    },
    { name: "CFG_SET_PARTITION52_HIGH",
       desc: "Index-based Partition Configuration [63:32] (upper 32 bit)",
       swaccess: "rw",
       hwaccess: "hrw",
       fields: [
        {bits: "31:0", name: "high", desc: "upper 32 bit"}
       ]
    },
    { name: "CFG_SET_PARTITION53_LOW",
       desc: "Index-based Partition Configuration [31:0] (lower 32 bit)",
       swaccess: "rw",
       hwaccess: "hrw",
       fields: [
        {bits: "31:0", name: "low", desc: "lower 32 bit"}
       ]
    },
    { name: "CFG_SET_PARTITION53_HIGH",
       desc: "Index-based Partition Configuration [63:32] (upper 32 bit)",
       swaccess: "rw",
       hwaccess: "hrw",
       fields: [
        {bits: "31:0", name: "high", desc: "upper 32 bit"}
       ]
    },
    { name: "CFG_SET_PARTITION54_LOW",
       desc: "Index-based Partition Configuration [31:0] (lower 32 bit)",
       swaccess: "rw",
       hwaccess: "hrw",
       fields: [
        {bits: "31:0", name: "low", desc: "lower 32 bit"}
       ]
    },
    { name: "CFG_SET_PARTITION54_HIGH",
       desc: "Index-based Partition Configuration [63:32] (upper 32 bit)",
       swaccess: "rw",
       hwaccess: "hrw",
       fields: [
        {bits: "31:0", name: "high", desc: "upper 32 bit"}
       ]
    },
    { name: "CFG_SET_PARTITION55_LOW",
       desc: "Index-based Partition Configuration [31:0] (lower 32 bit)",
       swaccess: "rw",
       hwaccess: "hrw",
       fields: [
        {bits: "31:0", name: "low", desc: "lower 32 bit"}
       ]
    },
    { name: "CFG_SET_PARTITION55_HIGH",
       desc: "Index-based Partition Configuration [63:32] (upper 32 bit)",
       swaccess: "rw",
       hwaccess: "hrw",
       fields: [
        {bits: "31:0", name: "high", desc: "upper 32 bit"}
       ]
    },
    { name: "CFG_SET_PARTITION56_LOW",
       desc: "Index-based Partition Configuration [31:0] (lower 32 bit)",
       swaccess: "rw",
       hwaccess: "hrw",
       fields: [
        {bits: "31:0", name: "low", desc: "lower 32 bit"}
       ]
    },
    { name: "CFG_SET_PARTITION56_HIGH",
       desc: "Index-based Partition Configuration [63:32] (upper 32 bit)",
       swaccess: "rw",
       hwaccess: "hrw",
       fields: [
        {bits: "31:0", name: "high", desc: "upper 32 bit"}
       ]
    },
    { name: "CFG_SET_PARTITION57_LOW",
       desc: "Index-based Partition Configuration [31:0] (lower 32 bit)",
       swaccess: "rw",
       hwaccess: "hrw",
       fields: [
        {bits: "31:0", name: "low", desc: "lower 32 bit"}
       ]
    },
    { name: "CFG_SET_PARTITION57_HIGH",
       desc: "Index-based Partition Configuration [63:32] (upper 32 bit)",
       swaccess: "rw",
       hwaccess: "hrw",
       fields: [
        {bits: "31:0", name: "high", desc: "upper 32 bit"}
       ]
    },
    { name: "CFG_SET_PARTITION58_LOW",
       desc: "Index-based Partition Configuration [31:0] (lower 32 bit)",
       swaccess: "rw",
       hwaccess: "hrw",
       fields: [
        {bits: "31:0", name: "low", desc: "lower 32 bit"}
       ]
    },
    { name: "CFG_SET_PARTITION58_HIGH",
       desc: "Index-based Partition Configuration [63:32] (upper 32 bit)",
       swaccess: "rw",
       hwaccess: "hrw",
       fields: [
        {bits: "31:0", name: "high", desc: "upper 32 bit"}
       ]
    },
    { name: "CFG_SET_PARTITION59_LOW",
       desc: "Index-based Partition Configuration [31:0] (lower 32 bit)",
       swaccess: "rw",
       hwaccess: "hrw",
       fields: [
        {bits: "31:0", name: "low", desc: "lower 32 bit"}
       ]
    },
    { name: "CFG_SET_PARTITION59_HIGH",
       desc: "Index-based Partition Configuration [63:32] (upper 32 bit)",
       swaccess: "rw",
       hwaccess: "hrw",
       fields: [
        {bits: "31:0", name: "high", desc: "upper 32 bit"}
       ]
    },
    { name: "CFG_SET_PARTITION60_LOW",
       desc: "Index-based Partition Configuration [31:0] (lower 32 bit)",
       swaccess: "rw",
       hwaccess: "hrw",
       fields: [
        {bits: "31:0", name: "low", desc: "lower 32 bit"}
       ]
    },
    { name: "CFG_SET_PARTITION60_HIGH",
       desc: "Index-based Partition Configuration [63:32] (upper 32 bit)",
       swaccess: "rw",
       hwaccess: "hrw",
       fields: [
        {bits: "31:0", name: "high", desc: "upper 32 bit"}
       ]
    },
    { name: "CFG_SET_PARTITION61_LOW",
       desc: "Index-based Partition Configuration [31:0] (lower 32 bit)",
       swaccess: "rw",
       hwaccess: "hrw",
       fields: [
        {bits: "31:0", name: "low", desc: "lower 32 bit"}
       ]
    },
    { name: "CFG_SET_PARTITION61_HIGH",
       desc: "Index-based Partition Configuration [63:32] (upper 32 bit)",
       swaccess: "rw",
       hwaccess: "hrw",
       fields: [
        {bits: "31:0", name: "high", desc: "upper 32 bit"}
       ]
    },
    { name: "CFG_SET_PARTITION62_LOW",
       desc: "Index-based Partition Configuration [31:0] (lower 32 bit)",
       swaccess: "rw",
       hwaccess: "hrw",
       fields: [
        {bits: "31:0", name: "low", desc: "lower 32 bit"}
       ]
    },
    { name: "CFG_SET_PARTITION62_HIGH",
       desc: "Index-based Partition Configuration [63:32] (upper 32 bit)",
       swaccess: "rw",
       hwaccess: "hrw",
       fields: [
        {bits: "31:0", name: "high", desc: "upper 32 bit"}
       ]
    },
    { name: "CFG_SET_PARTITION63_LOW",
       desc: "Index-based Partition Configuration [31:0] (lower 32 bit)",
       swaccess: "rw",
       hwaccess: "hrw",
       fields: [
        {bits: "31:0", name: "low", desc: "lower 32 bit"}
       ]
    },
    { name: "CFG_SET_PARTITION63_HIGH",
       desc: "Index-based Partition Configuration [63:32] (upper 32 bit)",
       swaccess: "rw",
       hwaccess: "hrw",
       fields: [
        {bits: "31:0", name: "high", desc: "upper 32 bit"}
       ]
    },
    { name: "CFG_SET_PARTITION64_LOW",
       desc: "Index-based Partition Configuration [31:0] (lower 32 bit)",
       swaccess: "rw",
       hwaccess: "hrw",
       fields: [
        {bits: "31:0", name: "low", desc: "lower 32 bit"}
       ]
    },
    { name: "CFG_SET_PARTITION64_HIGH",
       desc: "Index-based Partition Configuration [63:32] (upper 32 bit)",
       swaccess: "rw",
       hwaccess: "hrw",
       fields: [
        {bits: "31:0", name: "high", desc: "upper 32 bit"}
       ]
    },
    { name: "CFG_SET_PARTITION65_LOW",
       desc: "Index-based Partition Configuration [31:0] (lower 32 bit)",
       swaccess: "rw",
       hwaccess: "hrw",
       fields: [
        {bits: "31:0", name: "low", desc: "lower 32 bit"}
       ]
    },
    { name: "CFG_SET_PARTITION65_HIGH",
       desc: "Index-based Partition Configuration [63:32] (upper 32 bit)",
       swaccess: "rw",
       hwaccess: "hrw",
       fields: [
        {bits: "31:0", name: "high", desc: "upper 32 bit"}
       ]
    },
    { name: "CFG_SET_PARTITION66_LOW",
       desc: "Index-based Partition Configuration [31:0] (lower 32 bit)",
       swaccess: "rw",
       hwaccess: "hrw",
       fields: [
        {bits: "31:0", name: "low", desc: "lower 32 bit"}
       ]
    },
    { name: "CFG_SET_PARTITION66_HIGH",
       desc: "Index-based Partition Configuration [63:32] (upper 32 bit)",
       swaccess: "rw",
       hwaccess: "hrw",
       fields: [
        {bits: "31:0", name: "high", desc: "upper 32 bit"}
       ]
    },
    { name: "CFG_SET_PARTITION67_LOW",
       desc: "Index-based Partition Configuration [31:0] (lower 32 bit)",
       swaccess: "rw",
       hwaccess: "hrw",
       fields: [
        {bits: "31:0", name: "low", desc: "lower 32 bit"}
       ]
    },
    { name: "CFG_SET_PARTITION67_HIGH",
       desc: "Index-based Partition Configuration [63:32] (upper 32 bit)",
       swaccess: "rw",
       hwaccess: "hrw",
       fields: [
        {bits: "31:0", name: "high", desc: "upper 32 bit"}
       ]
    },
    { name: "CFG_SET_PARTITION68_LOW",
       desc: "Index-based Partition Configuration [31:0] (lower 32 bit)",
       swaccess: "rw",
       hwaccess: "hrw",
       fields: [
        {bits: "31:0", name: "low", desc: "lower 32 bit"}
       ]
    },
    { name: "CFG_SET_PARTITION68_HIGH",
       desc: "Index-based Partition Configuration [63:32] (upper 32 bit)",
       swaccess: "rw",
       hwaccess: "hrw",
       fields: [
        {bits: "31:0", name: "high", desc: "upper 32 bit"}
       ]
    },
    { name: "CFG_SET_PARTITION69_LOW",
       desc: "Index-based Partition Configuration [31:0] (lower 32 bit)",
       swaccess: "rw",
       hwaccess: "hrw",
       fields: [
        {bits: "31:0", name: "low", desc: "lower 32 bit"}
       ]
    },
    { name: "CFG_SET_PARTITION69_HIGH",
       desc: "Index-based Partition Configuration [63:32] (upper 32 bit)",
       swaccess: "rw",
       hwaccess: "hrw",
       fields: [
        {bits: "31:0", name: "high", desc: "upper 32 bit"}
       ]
    },
    { name: "CFG_SET_PARTITION70_LOW",
       desc: "Index-based Partition Configuration [31:0] (lower 32 bit)",
       swaccess: "rw",
       hwaccess: "hrw",
       fields: [
        {bits: "31:0", name: "low", desc: "lower 32 bit"}
       ]
    },
    { name: "CFG_SET_PARTITION70_HIGH",
       desc: "Index-based Partition Configuration [63:32] (upper 32 bit)",
       swaccess: "rw",
       hwaccess: "hrw",
       fields: [
        {bits: "31:0", name: "high", desc: "upper 32 bit"}
       ]
    },
    { name: "CFG_SET_PARTITION71_LOW",
       desc: "Index-based Partition Configuration [31:0] (lower 32 bit)",
       swaccess: "rw",
       hwaccess: "hrw",
       fields: [
        {bits: "31:0", name: "low", desc: "lower 32 bit"}
       ]
    },
    { name: "CFG_SET_PARTITION71_HIGH",
       desc: "Index-based Partition Configuration [63:32] (upper 32 bit)",
       swaccess: "rw",
       hwaccess: "hrw",
       fields: [
        {bits: "31:0", name: "high", desc: "upper 32 bit"}
       ]
    },
    { name: "CFG_SET_PARTITION72_LOW",
       desc: "Index-based Partition Configuration [31:0] (lower 32 bit)",
       swaccess: "rw",
       hwaccess: "hrw",
       fields: [
        {bits: "31:0", name: "low", desc: "lower 32 bit"}
       ]
    },
    { name: "CFG_SET_PARTITION72_HIGH",
       desc: "Index-based Partition Configuration [63:32] (upper 32 bit)",
       swaccess: "rw",
       hwaccess: "hrw",
       fields: [
        {bits: "31:0", name: "high", desc: "upper 32 bit"}
       ]
    },
    { name: "CFG_SET_PARTITION73_LOW",
       desc: "Index-based Partition Configuration [31:0] (lower 32 bit)",
       swaccess: "rw",
       hwaccess: "hrw",
       fields: [
        {bits: "31:0", name: "low", desc: "lower 32 bit"}
       ]
    },
    { name: "CFG_SET_PARTITION73_HIGH",
       desc: "Index-based Partition Configuration [63:32] (upper 32 bit)",
       swaccess: "rw",
       hwaccess: "hrw",
       fields: [
        {bits: "31:0", name: "high", desc: "upper 32 bit"}
       ]
    },

    { name: "COMMIT_CFG",
      desc: "Commit the configuration",
      swaccess: "rw1s",
      hwaccess: "hrw",
      fields: [
        {bits: "0", name: "commit", desc: "commit configuration"}
      ]
    },
    {skipto: "0x2a8"}
    { name: "COMMIT_PARTITION_CFG",
      desc: "Commit the set partition configuration",
      swaccess: "rw1s",
      hwaccess: "hrw",
      fields: [
        {bits: "0", name: "commit", desc: "commit set partition configuration"}
      ]
    },
    {skipto: "0x2b0"}
    { name: "FLUSHED_LOW",
      desc: "Flushed Flag (lower 32 bit)",
      swaccess: "ro",
      hwaccess: "hrw",
      fields: [
        {bits: "31:0", name: "low", desc: "lower 32 bit"}
      ]
    },
    { name: "FLUSHED_HIGH",
      desc: "Flushed Flag (upper 32 bit)",
      swaccess: "ro",
      hwaccess: "hrw",
      fields: [
        {bits: "31:0", name: "high", desc: "upper 32 bit"}
      ]
    },
    { name: "BIST_OUT_LOW",
      desc: "Tag Storage BIST Result (lower 32 bit)",
      swaccess: "ro",
      hwaccess: "hwo",
      fields: [
        {bits: "31:0", name: "low", desc: "lower 32 bit"}
      ]
    },
    { name: "BIST_OUT_HIGH",
      desc: "Tag Storage BIST Result (upper 32 bit)",
      swaccess: "ro",
      hwaccess: "hwo",
      fields: [
        {bits: "31:0", name: "high", desc: "upper 32 bit"}
      ]
    },
    { name: "SET_ASSO_LOW",
      desc: "Instantiated Set-Associativity (lower 32 bit)",
      swaccess: "ro",
      hwaccess: "hwo",
      fields: [
        {bits: "31:0", name: "low", desc: "lower 32 bit"}
      ]
    },
    { name: "SET_ASSO_HIGH",
      desc: "Instantiated Set-Associativity (upper 32 bit)",
      swaccess: "ro",
      hwaccess: "hwo",
      fields: [
        {bits: "31:0", name: "high", desc: "upper 32 bit"}
      ]
    },
    { name: "NUM_LINES_LOW",
      desc: "Instantiated Number of Cache-Lines (lower 32 bit)",
      swaccess: "ro",
      hwaccess: "hwo",
      fields: [
        {bits: "31:0", name: "low", desc: "lower 32 bit"}
      ]
    },
    { name: "NUM_LINES_HIGH",
      desc: "Instantiated Number of Cache-Lines (upper 32 bit)",
      swaccess: "ro",
      hwaccess: "hwo",
      fields: [
        {bits: "31:0", name: "high", desc: "upper 32 bit"}
      ]
    },
    { name: "NUM_BLOCKS_LOW",
      desc: "Instantiated Number of Blocks (lower 32 bit)",
      swaccess: "ro",
      hwaccess: "hwo",
      fields: [
        {bits: "31:0", name: "low", desc: "lower 32 bit"}
      ]
    },
    { name: "NUM_BLOCKS_HIGH",
      desc: "Instantiated Number of Blocks (upper 32 bit)",
      swaccess: "ro",
      hwaccess: "hwo",
      fields: [
        {bits: "31:0", name: "high", desc: "upper 32 bit"}
      ]
    },
    { name: "VERSION_LOW",
      desc: "AXI LLC Version (lower 32 bit)",
      swaccess: "ro",
      hwaccess: "hwo",
      fields: [
        {bits: "31:0", name: "low", desc: "lower 32 bit"}
      ]
    },
    { name: "VERSION_HIGH",
      desc: "AXI LLC Version (upper 32 bit)",
      swaccess: "ro",
      hwaccess: "hwo",
      fields: [
        {bits: "31:0", name: "high", desc: "upper 32 bit"}
      ]
    },
    { name: "FLUSHED_SET0_LOW",
      desc: "Index-based Flushed Flag [31:0] (lower 32 bit)",
      swaccess: "ro",
      hwaccess: "hrw",
      fields: [
        {bits: "31:0", name: "low", desc: "lower 32 bit"}
      ]
    },
    { name: "FLUSHED_SET0_HIGH",
      desc: "Index-based Flushed Flag [63:32] (upper 32 bit)",
      swaccess: "ro",
      hwaccess: "hrw",
      fields: [
        {bits: "31:0", name: "high", desc: "upper 32 bit"}
      ]
    },
    { name: "FLUSHED_SET1_LOW",
      desc: "Index-based Flushed Flag [95:64] (lower 32 bit)",
      swaccess: "ro",
      hwaccess: "hrw",
      fields: [
        {bits: "31:0", name: "low", desc: "lower 32 bit"}
      ]
    },
    { name: "FLUSHED_SET1_HIGH",
      desc: "Index-based Flushed Flag [127:96] (upper 32 bit)",
      swaccess: "ro",
      hwaccess: "hrw",
      fields: [
        {bits: "31:0", name: "high", desc: "upper 32 bit"}
      ]
    },
    { name: "FLUSHED_SET2_LOW",
      desc: "Index-based Flushed Flag [159:128] (lower 32 bit)",
      swaccess: "ro",
      hwaccess: "hrw",
      fields: [
        {bits: "31:0", name: "low", desc: "lower 32 bit"}
      ]
    },
    { name: "FLUSHED_SET2_HIGH",
      desc: "Index-based Flushed Flag [191:160] (upper 32 bit)",
      swaccess: "ro",
      hwaccess: "hrw",
      fields: [
        {bits: "31:0", name: "high", desc: "upper 32 bit"}
      ]
    },
    { name: "FLUSHED_SET3_LOW",
      desc: "Index-based Flushed Flag [223:192] (lower 32 bit)",
      swaccess: "ro",
      hwaccess: "hrw",
      fields: [
        {bits: "31:0", name: "low", desc: "lower 32 bit"}
      ]
    },
    { name: "FLUSHED_SET3_HIGH",
      desc: "Index-based Flushed Flag [255:224] (upper 32 bit)",
      swaccess: "ro",
      hwaccess: "hrw",
      fields: [
        {bits: "31:0", name: "high", desc: "upper 32 bit"}
      ]
    },
    { name: "FLUSHED_SET4_LOW",
      desc: "Index-based Flushed Flag [287:256] (lower 32 bit)",
      swaccess: "ro",
      hwaccess: "hrw",
      fields: [
        {bits: "31:0", name: "low", desc: "lower 32 bit"}
      ]
    },
    { name: "FLUSHED_SET4_HIGH",
      desc: "Index-based Flushed Flag [319:288] (upper 32 bit)",
      swaccess: "ro",
      hwaccess: "hrw",
      fields: [
        {bits: "31:0", name: "high", desc: "upper 32 bit"}
      ]
    },
    { name: "FLUSHED_SET5_LOW",
      desc: "Index-based Flushed Flag [351:320] (lower 32 bit)",
      swaccess: "ro",
      hwaccess: "hrw",
      fields: [
        {bits: "31:0", name: "low", desc: "lower 32 bit"}
      ]
    },
    { name: "FLUSHED_SET5_HIGH",
      desc: "Index-based Flushed Flag [383:352] (upper 32 bit)",
      swaccess: "ro",
      hwaccess: "hrw",
      fields: [
        {bits: "31:0", name: "high", desc: "upper 32 bit"}
      ]
    },
    { name: "FLUSHED_SET6_LOW",
      desc: "Index-based Flushed Flag [415:384] (lower 32 bit)",
      swaccess: "ro",
      hwaccess: "hrw",
      fields: [
        {bits: "31:0", name: "low", desc: "lower 32 bit"}
      ]
    },
    { name: "FLUSHED_SET6_HIGH",
      desc: "Index-based Flushed Flag [447:416] (upper 32 bit)",
      swaccess: "ro",
      hwaccess: "hrw",
      fields: [
        {bits: "31:0", name: "high", desc: "upper 32 bit"}
      ]
    },
    { name: "FLUSHED_SET7_LOW",
      desc: "Index-based Flushed Flag [479:448] (lower 32 bit)",
      swaccess: "ro",
      hwaccess: "hrw",
      fields: [
        {bits: "31:0", name: "low", desc: "lower 32 bit"}
      ]
    },
    { name: "FLUSHED_SET7_HIGH",
      desc: "Index-based Flushed Flag [511:480] (upper 32 bit)",
      swaccess: "ro",
      hwaccess: "hrw",
      fields: [
        {bits: "31:0", name: "high", desc: "upper 32 bit"}
      ]
    }
  ]
}
