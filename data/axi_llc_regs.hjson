// Copyright 2018-2021 ETH Zurich and University of Bologna.
// Solderpad Hardware License, Version 0.51, see LICENSE for details.
// SPDX-License-Identifier: SHL-0.51
//
// Authors: 
// Nicole Narr <narrn@ethz.ch>
// Christopher Reinwardt <creinwar@ethz.ch>



{
  name: "axi_llc",
  clock_primary: "clk_i",
  bus_interfaces: [
    { protocol: "reg_iface", direction: "device" }
  ],
  regwidth: 32,
  registers: [

    { name: "CFG_SPM_LOW",
      desc: "SPM Configuration (lower 32 bit)",
      swaccess: "rw",
      hwaccess: "hrw",
      fields: [
        {bits: "31:0", resval: 0, name: "low", desc: "lower 32 bit"}
      ]
    },
    { name: "CFG_SPM_HIGH",
      desc: "SPM Configuration (upper 32 bit)",
      swaccess: "rw",
      hwaccess: "hrw",
      fields: [
        {bits: "31:0", name: "high", desc: "upper 32 bit"}
      ]
    },
    { name: "CFG_FLUSH_LOW",
      desc: "Flush Configuration (lower 32 bit)",
      swaccess: "rw",
      hwaccess: "hrw",
      fields: [
        {bits: "31:0", name: "low", desc: "lower 32 bit"}
      ]
    },
    { name: "CFG_FLUSH_HIGH",
      desc: "Flush Configuration (upper 32 bit)",
      swaccess: "rw",
      hwaccess: "hrw",
      fields: [
        {bits: "31:0", name: "high", desc: "upper 32 bit"}
      ]
    },
    { name: "CFG_FLUSH_SET0_LOW",
      desc: "Index-based Flush Configuration [31:0] (lower 32 bit)",
      swaccess: "rw",
      hwaccess: "hrw",
      fields: [
        {bits: "31:0", name: "low", desc: "lower 32 bit"}
      ]
    },
    { name: "CFG_FLUSH_SET0_HIGH",
      desc: "Index-based Flush Configuration [63:32] (upper 32 bit)",
      swaccess: "rw",
      hwaccess: "hrw",
      fields: [
        {bits: "31:0", name: "high", desc: "upper 32 bit"}
      ]
    },
    { name: "CFG_FLUSH_SET1_LOW",
      desc: "Index-based Flush Configuration [95:64] (lower 32 bit)",
      swaccess: "rw",
      hwaccess: "hrw",
      fields: [
        {bits: "31:0", name: "low", desc: "lower 32 bit"}
      ]
    },
    { name: "CFG_FLUSH_SET1_HIGH",
      desc: "Index-based Flush Configuration [127:96] (upper 32 bit)",
      swaccess: "rw",
      hwaccess: "hrw",
      fields: [
        {bits: "31:0", name: "high", desc: "upper 32 bit"}
      ]
    },
    { name: "CFG_FLUSH_SET2_LOW",
      desc: "Index-based Flush Configuration [159:128] (lower 32 bit)",
      swaccess: "rw",
      hwaccess: "hrw",
      fields: [
        {bits: "31:0", name: "low", desc: "lower 32 bit"}
      ]
    },
    { name: "CFG_FLUSH_SET2_HIGH",
      desc: "Index-based Flush Configuration [191:160] (upper 32 bit)",
      swaccess: "rw",
      hwaccess: "hrw",
      fields: [
        {bits: "31:0", name: "high", desc: "upper 32 bit"}
      ]
    },
    { name: "CFG_FLUSH_SET3_LOW",
      desc: "Index-based Flush Configuration [223:192] (lower 32 bit)",
      swaccess: "rw",
      hwaccess: "hrw",
      fields: [
        {bits: "31:0", name: "low", desc: "lower 32 bit"}
      ]
    },
    { name: "CFG_FLUSH_SET3_HIGH",
      desc: "Index-based Flush Configuration [255:224] (upper 32 bit)",
      swaccess: "rw",
      hwaccess: "hrw",
      fields: [
        {bits: "31:0", name: "high", desc: "upper 32 bit"}
      ]
    },
    { name: "CFG_SET_PARTITION0_LOW",
       desc: "Index-based Partition Configuration [31:0] (lower 32 bit)",
       swaccess: "rw",
       hwaccess: "hrw",
       fields: [
        {bits: "31:0", name: "low", desc: "lower 32 bit"}
       ]
    },
    { name: "CFG_SET_PARTITION0_HIGH",
       desc: "Index-based Partition Configuration [63:32] (upper 32 bit)",
       swaccess: "rw",
       hwaccess: "hrw",
       fields: [
        {bits: "31:0", name: "high", desc: "upper 32 bit"}
       ]
    },
    { name: "CFG_SET_PARTITION1_LOW",
       desc: "Index-based Partition Configuration [31:0] (lower 32 bit)",
       swaccess: "rw",
       hwaccess: "hrw",
       fields: [
        {bits: "31:0", name: "low", desc: "lower 32 bit"}
       ]
    },
    { name: "CFG_SET_PARTITION1_HIGH",
       desc: "Index-based Partition Configuration [63:32] (upper 32 bit)",
       swaccess: "rw",
       hwaccess: "hrw",
       fields: [
        {bits: "31:0", name: "high", desc: "upper 32 bit"}
       ]
    },
    { name: "CFG_SET_PARTITION2_LOW",
       desc: "Index-based Partition Configuration [31:0] (lower 32 bit)",
       swaccess: "rw",
       hwaccess: "hrw",
       fields: [
        {bits: "31:0", name: "low", desc: "lower 32 bit"}
       ]
    },
    { name: "CFG_SET_PARTITION2_HIGH",
       desc: "Index-based Partition Configuration [63:32] (upper 32 bit)",
       swaccess: "rw",
       hwaccess: "hrw",
       fields: [
        {bits: "31:0", name: "high", desc: "upper 32 bit"}
       ]
    },
    { name: "CFG_SET_PARTITION3_LOW",
       desc: "Index-based Partition Configuration [31:0] (lower 32 bit)",
       swaccess: "rw",
       hwaccess: "hrw",
       fields: [
        {bits: "31:0", name: "low", desc: "lower 32 bit"}
       ]
    },
    { name: "CFG_SET_PARTITION3_HIGH",
       desc: "Index-based Partition Configuration [63:32] (upper 32 bit)",
       swaccess: "rw",
       hwaccess: "hrw",
       fields: [
        {bits: "31:0", name: "high", desc: "upper 32 bit"}
       ]
    },
    { name: "CFG_SET_PARTITION4_LOW",
       desc: "Index-based Partition Configuration [31:0] (lower 32 bit)",
       swaccess: "rw",
       hwaccess: "hrw",
       fields: [
        {bits: "31:0", name: "low", desc: "lower 32 bit"}
       ]
    },
    { name: "CFG_SET_PARTITION4_HIGH",
       desc: "Index-based Partition Configuration [63:32] (upper 32 bit)",
       swaccess: "rw",
       hwaccess: "hrw",
       fields: [
        {bits: "31:0", name: "high", desc: "upper 32 bit"}
       ]
    },
    { name: "CFG_SET_PARTITION5_LOW",
       desc: "Index-based Partition Configuration [31:0] (lower 32 bit)",
       swaccess: "rw",
       hwaccess: "hrw",
       fields: [
        {bits: "31:0", name: "low", desc: "lower 32 bit"}
       ]
    },
    { name: "CFG_SET_PARTITION5_HIGH",
       desc: "Index-based Partition Configuration [63:32] (upper 32 bit)",
       swaccess: "rw",
       hwaccess: "hrw",
       fields: [
        {bits: "31:0", name: "high", desc: "upper 32 bit"}
       ]
    },
    { name: "CFG_SET_PARTITION6_LOW",
       desc: "Index-based Partition Configuration [31:0] (lower 32 bit)",
       swaccess: "rw",
       hwaccess: "hrw",
       fields: [
        {bits: "31:0", name: "low", desc: "lower 32 bit"}
       ]
    },
    { name: "CFG_SET_PARTITION6_HIGH",
       desc: "Index-based Partition Configuration [63:32] (upper 32 bit)",
       swaccess: "rw",
       hwaccess: "hrw",
       fields: [
        {bits: "31:0", name: "high", desc: "upper 32 bit"}
       ]
    },
    { name: "CFG_SET_PARTITION7_LOW",
       desc: "Index-based Partition Configuration [31:0] (lower 32 bit)",
       swaccess: "rw",
       hwaccess: "hrw",
       fields: [
        {bits: "31:0", name: "low", desc: "lower 32 bit"}
       ]
    },
    { name: "CFG_SET_PARTITION7_HIGH",
       desc: "Index-based Partition Configuration [63:32] (upper 32 bit)",
       swaccess: "rw",
       hwaccess: "hrw",
       fields: [
        {bits: "31:0", name: "high", desc: "upper 32 bit"}
       ]
    },
    { name: "CFG_SET_PARTITION8_LOW",
       desc: "Index-based Partition Configuration [31:0] (lower 32 bit)",
       swaccess: "rw",
       hwaccess: "hrw",
       fields: [
        {bits: "31:0", name: "low", desc: "lower 32 bit"}
       ]
    },
    { name: "CFG_SET_PARTITION8_HIGH",
       desc: "Index-based Partition Configuration [63:32] (upper 32 bit)",
       swaccess: "rw",
       hwaccess: "hrw",
       fields: [
        {bits: "31:0", name: "high", desc: "upper 32 bit"}
       ]
    },
    { name: "CFG_SET_PARTITION9_LOW",
       desc: "Index-based Partition Configuration [31:0] (lower 32 bit)",
       swaccess: "rw",
       hwaccess: "hrw",
       fields: [
        {bits: "31:0", name: "low", desc: "lower 32 bit"}
       ]
    },
    { name: "CFG_SET_PARTITION9_HIGH",
       desc: "Index-based Partition Configuration [63:32] (upper 32 bit)",
       swaccess: "rw",
       hwaccess: "hrw",
       fields: [
        {bits: "31:0", name: "high", desc: "upper 32 bit"}
       ]
    },
    { name: "CFG_SET_PARTITION10_LOW",
       desc: "Index-based Partition Configuration [31:0] (lower 32 bit)",
       swaccess: "rw",
       hwaccess: "hrw",
       fields: [
        {bits: "31:0", name: "low", desc: "lower 32 bit"}
       ]
    },
    { name: "CFG_SET_PARTITION10_HIGH",
       desc: "Index-based Partition Configuration [63:32] (upper 32 bit)",
       swaccess: "rw",
       hwaccess: "hrw",
       fields: [
        {bits: "31:0", name: "high", desc: "upper 32 bit"}
       ]
    },
    { name: "CFG_SET_PARTITION11_LOW",
       desc: "Index-based Partition Configuration [31:0] (lower 32 bit)",
       swaccess: "rw",
       hwaccess: "hrw",
       fields: [
        {bits: "31:0", name: "low", desc: "lower 32 bit"}
       ]
    },
    { name: "CFG_SET_PARTITION11_HIGH",
       desc: "Index-based Partition Configuration [63:32] (upper 32 bit)",
       swaccess: "rw",
       hwaccess: "hrw",
       fields: [
        {bits: "31:0", name: "high", desc: "upper 32 bit"}
       ]
    },
    { name: "CFG_SET_PARTITION12_LOW",
       desc: "Index-based Partition Configuration [31:0] (lower 32 bit)",
       swaccess: "rw",
       hwaccess: "hrw",
       fields: [
        {bits: "31:0", name: "low", desc: "lower 32 bit"}
       ]
    },
    { name: "CFG_SET_PARTITION12_HIGH",
       desc: "Index-based Partition Configuration [63:32] (upper 32 bit)",
       swaccess: "rw",
       hwaccess: "hrw",
       fields: [
        {bits: "31:0", name: "high", desc: "upper 32 bit"}
       ]
    },
    { name: "CFG_SET_PARTITION13_LOW",
       desc: "Index-based Partition Configuration [31:0] (lower 32 bit)",
       swaccess: "rw",
       hwaccess: "hrw",
       fields: [
        {bits: "31:0", name: "low", desc: "lower 32 bit"}
       ]
    },
    { name: "CFG_SET_PARTITION13_HIGH",
       desc: "Index-based Partition Configuration [63:32] (upper 32 bit)",
       swaccess: "rw",
       hwaccess: "hrw",
       fields: [
        {bits: "31:0", name: "high", desc: "upper 32 bit"}
       ]
    },
    { name: "CFG_SET_PARTITION14_LOW",
       desc: "Index-based Partition Configuration [31:0] (lower 32 bit)",
       swaccess: "rw",
       hwaccess: "hrw",
       fields: [
        {bits: "31:0", name: "low", desc: "lower 32 bit"}
       ]
    },
    { name: "CFG_SET_PARTITION14_HIGH",
       desc: "Index-based Partition Configuration [63:32] (upper 32 bit)",
       swaccess: "rw",
       hwaccess: "hrw",
       fields: [
        {bits: "31:0", name: "high", desc: "upper 32 bit"}
       ]
    },
    { name: "CFG_SET_PARTITION15_LOW",
       desc: "Index-based Partition Configuration [31:0] (lower 32 bit)",
       swaccess: "rw",
       hwaccess: "hrw",
       fields: [
        {bits: "31:0", name: "low", desc: "lower 32 bit"}
       ]
    },
    { name: "CFG_SET_PARTITION15_HIGH",
       desc: "Index-based Partition Configuration [63:32] (upper 32 bit)",
       swaccess: "rw",
       hwaccess: "hrw",
       fields: [
        {bits: "31:0", name: "high", desc: "upper 32 bit"}
       ]
    },
    { name: "CFG_SET_PARTITION16_LOW",
       desc: "Index-based Partition Configuration [31:0] (lower 32 bit)",
       swaccess: "rw",
       hwaccess: "hrw",
       fields: [
        {bits: "31:0", name: "low", desc: "lower 32 bit"}
       ]
    },
    { name: "CFG_SET_PARTITION16_HIGH",
       desc: "Index-based Partition Configuration [63:32] (upper 32 bit)",
       swaccess: "rw",
       hwaccess: "hrw",
       fields: [
        {bits: "31:0", name: "high", desc: "upper 32 bit"}
       ]
    },
    { name: "CFG_SET_PARTITION17_LOW",
       desc: "Index-based Partition Configuration [31:0] (lower 32 bit)",
       swaccess: "rw",
       hwaccess: "hrw",
       fields: [
        {bits: "31:0", name: "low", desc: "lower 32 bit"}
       ]
    },
    { name: "CFG_SET_PARTITION17_HIGH",
       desc: "Index-based Partition Configuration [63:32] (upper 32 bit)",
       swaccess: "rw",
       hwaccess: "hrw",
       fields: [
        {bits: "31:0", name: "high", desc: "upper 32 bit"}
       ]
    },
    { name: "CFG_SET_PARTITION18_LOW",
       desc: "Index-based Partition Configuration [31:0] (lower 32 bit)",
       swaccess: "rw",
       hwaccess: "hrw",
       fields: [
        {bits: "31:0", name: "low", desc: "lower 32 bit"}
       ]
    },
    { name: "CFG_SET_PARTITION18_HIGH",
       desc: "Index-based Partition Configuration [63:32] (upper 32 bit)",
       swaccess: "rw",
       hwaccess: "hrw",
       fields: [
        {bits: "31:0", name: "high", desc: "upper 32 bit"}
       ]
    },
    { name: "CFG_SET_PARTITION19_LOW",
       desc: "Index-based Partition Configuration [31:0] (lower 32 bit)",
       swaccess: "rw",
       hwaccess: "hrw",
       fields: [
        {bits: "31:0", name: "low", desc: "lower 32 bit"}
       ]
    },
    { name: "CFG_SET_PARTITION19_HIGH",
       desc: "Index-based Partition Configuration [63:32] (upper 32 bit)",
       swaccess: "rw",
       hwaccess: "hrw",
       fields: [
        {bits: "31:0", name: "high", desc: "upper 32 bit"}
       ]
    },
    { name: "CFG_SET_PARTITION20_LOW",
       desc: "Index-based Partition Configuration [31:0] (lower 32 bit)",
       swaccess: "rw",
       hwaccess: "hrw",
       fields: [
        {bits: "31:0", name: "low", desc: "lower 32 bit"}
       ]
    },
    { name: "CFG_SET_PARTITION20_HIGH",
       desc: "Index-based Partition Configuration [63:32] (upper 32 bit)",
       swaccess: "rw",
       hwaccess: "hrw",
       fields: [
        {bits: "31:0", name: "high", desc: "upper 32 bit"}
       ]
    },
    { name: "CFG_SET_PARTITION21_LOW",
       desc: "Index-based Partition Configuration [31:0] (lower 32 bit)",
       swaccess: "rw",
       hwaccess: "hrw",
       fields: [
        {bits: "31:0", name: "low", desc: "lower 32 bit"}
       ]
    },
    { name: "CFG_SET_PARTITION21_HIGH",
       desc: "Index-based Partition Configuration [63:32] (upper 32 bit)",
       swaccess: "rw",
       hwaccess: "hrw",
       fields: [
        {bits: "31:0", name: "high", desc: "upper 32 bit"}
       ]
    },
    { name: "CFG_SET_PARTITION22_LOW",
       desc: "Index-based Partition Configuration [31:0] (lower 32 bit)",
       swaccess: "rw",
       hwaccess: "hrw",
       fields: [
        {bits: "31:0", name: "low", desc: "lower 32 bit"}
       ]
    },
    { name: "CFG_SET_PARTITION22_HIGH",
       desc: "Index-based Partition Configuration [63:32] (upper 32 bit)",
       swaccess: "rw",
       hwaccess: "hrw",
       fields: [
        {bits: "31:0", name: "high", desc: "upper 32 bit"}
       ]
    },
    { name: "CFG_SET_PARTITION23_LOW",
       desc: "Index-based Partition Configuration [31:0] (lower 32 bit)",
       swaccess: "rw",
       hwaccess: "hrw",
       fields: [
        {bits: "31:0", name: "low", desc: "lower 32 bit"}
       ]
    },
    { name: "CFG_SET_PARTITION23_HIGH",
       desc: "Index-based Partition Configuration [63:32] (upper 32 bit)",
       swaccess: "rw",
       hwaccess: "hrw",
       fields: [
        {bits: "31:0", name: "high", desc: "upper 32 bit"}
       ]
    },
    { name: "CFG_SET_PARTITION24_LOW",
       desc: "Index-based Partition Configuration [31:0] (lower 32 bit)",
       swaccess: "rw",
       hwaccess: "hrw",
       fields: [
        {bits: "31:0", name: "low", desc: "lower 32 bit"}
       ]
    },
    { name: "CFG_SET_PARTITION24_HIGH",
       desc: "Index-based Partition Configuration [63:32] (upper 32 bit)",
       swaccess: "rw",
       hwaccess: "hrw",
       fields: [
        {bits: "31:0", name: "high", desc: "upper 32 bit"}
       ]
    },
    { name: "CFG_SET_PARTITION25_LOW",
       desc: "Index-based Partition Configuration [31:0] (lower 32 bit)",
       swaccess: "rw",
       hwaccess: "hrw",
       fields: [
        {bits: "31:0", name: "low", desc: "lower 32 bit"}
       ]
    },
    { name: "CFG_SET_PARTITION25_HIGH",
       desc: "Index-based Partition Configuration [63:32] (upper 32 bit)",
       swaccess: "rw",
       hwaccess: "hrw",
       fields: [
        {bits: "31:0", name: "high", desc: "upper 32 bit"}
       ]
    },
    { name: "CFG_SET_PARTITION26_LOW",
       desc: "Index-based Partition Configuration [31:0] (lower 32 bit)",
       swaccess: "rw",
       hwaccess: "hrw",
       fields: [
        {bits: "31:0", name: "low", desc: "lower 32 bit"}
       ]
    },
    { name: "CFG_SET_PARTITION26_HIGH",
       desc: "Index-based Partition Configuration [63:32] (upper 32 bit)",
       swaccess: "rw",
       hwaccess: "hrw",
       fields: [
        {bits: "31:0", name: "high", desc: "upper 32 bit"}
       ]
    },
    { name: "CFG_SET_PARTITION27_LOW",
       desc: "Index-based Partition Configuration [31:0] (lower 32 bit)",
       swaccess: "rw",
       hwaccess: "hrw",
       fields: [
        {bits: "31:0", name: "low", desc: "lower 32 bit"}
       ]
    },
    { name: "CFG_SET_PARTITION27_HIGH",
       desc: "Index-based Partition Configuration [63:32] (upper 32 bit)",
       swaccess: "rw",
       hwaccess: "hrw",
       fields: [
        {bits: "31:0", name: "high", desc: "upper 32 bit"}
       ]
    },
    { name: "CFG_SET_PARTITION28_LOW",
       desc: "Index-based Partition Configuration [31:0] (lower 32 bit)",
       swaccess: "rw",
       hwaccess: "hrw",
       fields: [
        {bits: "31:0", name: "low", desc: "lower 32 bit"}
       ]
    },
    { name: "CFG_SET_PARTITION28_HIGH",
       desc: "Index-based Partition Configuration [63:32] (upper 32 bit)",
       swaccess: "rw",
       hwaccess: "hrw",
       fields: [
        {bits: "31:0", name: "high", desc: "upper 32 bit"}
       ]
    },
    { name: "CFG_SET_PARTITION29_LOW",
       desc: "Index-based Partition Configuration [31:0] (lower 32 bit)",
       swaccess: "rw",
       hwaccess: "hrw",
       fields: [
        {bits: "31:0", name: "low", desc: "lower 32 bit"}
       ]
    },
    { name: "CFG_SET_PARTITION29_HIGH",
       desc: "Index-based Partition Configuration [63:32] (upper 32 bit)",
       swaccess: "rw",
       hwaccess: "hrw",
       fields: [
        {bits: "31:0", name: "high", desc: "upper 32 bit"}
       ]
    },
    { name: "CFG_SET_PARTITION30_LOW",
       desc: "Index-based Partition Configuration [31:0] (lower 32 bit)",
       swaccess: "rw",
       hwaccess: "hrw",
       fields: [
        {bits: "31:0", name: "low", desc: "lower 32 bit"}
       ]
    },
    { name: "CFG_SET_PARTITION30_HIGH",
       desc: "Index-based Partition Configuration [63:32] (upper 32 bit)",
       swaccess: "rw",
       hwaccess: "hrw",
       fields: [
        {bits: "31:0", name: "high", desc: "upper 32 bit"}
       ]
    },
    { name: "CFG_SET_PARTITION31_LOW",
       desc: "Index-based Partition Configuration [31:0] (lower 32 bit)",
       swaccess: "rw",
       hwaccess: "hrw",
       fields: [
        {bits: "31:0", name: "low", desc: "lower 32 bit"}
       ]
    },
    { name: "CFG_SET_PARTITION31_HIGH",
       desc: "Index-based Partition Configuration [63:32] (upper 32 bit)",
       swaccess: "rw",
       hwaccess: "hrw",
       fields: [
        {bits: "31:0", name: "high", desc: "upper 32 bit"}
       ]
    },

    { name: "COMMIT_CFG",
      desc: "Commit the configuration",
      swaccess: "rw1s",
      hwaccess: "hrw",
      fields: [
        {bits: "0", name: "commit", desc: "commit configuration"}
      ]
    },
    {skipto: "0x138"}
    { name: "COMMIT_PARTITION_CFG",
      desc: "Commit the set partition configuration",
      swaccess: "rw1s",
      hwaccess: "hrw",
      fields: [
        {bits: "0", name: "commit", desc: "commit set partition configuration"}
      ]
    },
    {skipto: "0x140"}
    { name: "FLUSHED_LOW",
      desc: "Flushed Flag (lower 32 bit)",
      swaccess: "ro",
      hwaccess: "hrw",
      fields: [
        {bits: "31:0", name: "low", desc: "lower 32 bit"}
      ]
    },
    { name: "FLUSHED_HIGH",
      desc: "Flushed Flag (upper 32 bit)",
      swaccess: "ro",
      hwaccess: "hrw",
      fields: [
        {bits: "31:0", name: "high", desc: "upper 32 bit"}
      ]
    },
    { name: "BIST_OUT_LOW",
      desc: "Tag Storage BIST Result (lower 32 bit)",
      swaccess: "ro",
      hwaccess: "hwo",
      fields: [
        {bits: "31:0", name: "low", desc: "lower 32 bit"}
      ]
    },
    { name: "BIST_OUT_HIGH",
      desc: "Tag Storage BIST Result (upper 32 bit)",
      swaccess: "ro",
      hwaccess: "hwo",
      fields: [
        {bits: "31:0", name: "high", desc: "upper 32 bit"}
      ]
    },
    { name: "SET_ASSO_LOW",
      desc: "Instantiated Set-Associativity (lower 32 bit)",
      swaccess: "ro",
      hwaccess: "hwo",
      fields: [
        {bits: "31:0", name: "low", desc: "lower 32 bit"}
      ]
    },
    { name: "SET_ASSO_HIGH",
      desc: "Instantiated Set-Associativity (upper 32 bit)",
      swaccess: "ro",
      hwaccess: "hwo",
      fields: [
        {bits: "31:0", name: "high", desc: "upper 32 bit"}
      ]
    },
    { name: "NUM_LINES_LOW",
      desc: "Instantiated Number of Cache-Lines (lower 32 bit)",
      swaccess: "ro",
      hwaccess: "hwo",
      fields: [
        {bits: "31:0", name: "low", desc: "lower 32 bit"}
      ]
    },
    { name: "NUM_LINES_HIGH",
      desc: "Instantiated Number of Cache-Lines (upper 32 bit)",
      swaccess: "ro",
      hwaccess: "hwo",
      fields: [
        {bits: "31:0", name: "high", desc: "upper 32 bit"}
      ]
    },
    { name: "NUM_BLOCKS_LOW",
      desc: "Instantiated Number of Blocks (lower 32 bit)",
      swaccess: "ro",
      hwaccess: "hwo",
      fields: [
        {bits: "31:0", name: "low", desc: "lower 32 bit"}
      ]
    },
    { name: "NUM_BLOCKS_HIGH",
      desc: "Instantiated Number of Blocks (upper 32 bit)",
      swaccess: "ro",
      hwaccess: "hwo",
      fields: [
        {bits: "31:0", name: "high", desc: "upper 32 bit"}
      ]
    },
    { name: "VERSION_LOW",
      desc: "AXI LLC Version (lower 32 bit)",
      swaccess: "ro",
      hwaccess: "hwo",
      fields: [
        {bits: "31:0", name: "low", desc: "lower 32 bit"}
      ]
    },
    { name: "VERSION_HIGH",
      desc: "AXI LLC Version (upper 32 bit)",
      swaccess: "ro",
      hwaccess: "hwo",
      fields: [
        {bits: "31:0", name: "high", desc: "upper 32 bit"}
      ]
    },
    { name: "BIST_STATUS",
      desc: "Status register of the BIST",
      swaccess: "ro",
      hwaccess: "hwo",
      fields: [
        {bits: "0:0", name: "done", desc: "BIST successfully completed"}
      ]
    },
    { name: "FLUSHED_SET0_LOW",
      desc: "Index-based Flushed Flag [31:0] (lower 32 bit)",
      swaccess: "ro",
      hwaccess: "hrw",
      fields: [
        {bits: "31:0", name: "low", desc: "lower 32 bit"}
      ]
    },
    { name: "FLUSHED_SET0_HIGH",
      desc: "Index-based Flushed Flag [63:32] (upper 32 bit)",
      swaccess: "ro",
      hwaccess: "hrw",
      fields: [
        {bits: "31:0", name: "high", desc: "upper 32 bit"}
      ]
    },
    { name: "FLUSHED_SET1_LOW",
      desc: "Index-based Flushed Flag [95:64] (lower 32 bit)",
      swaccess: "ro",
      hwaccess: "hrw",
      fields: [
        {bits: "31:0", name: "low", desc: "lower 32 bit"}
      ]
    },
    { name: "FLUSHED_SET1_HIGH",
      desc: "Index-based Flushed Flag [127:96] (upper 32 bit)",
      swaccess: "ro",
      hwaccess: "hrw",
      fields: [
        {bits: "31:0", name: "high", desc: "upper 32 bit"}
      ]
    },
    { name: "FLUSHED_SET2_LOW",
      desc: "Index-based Flushed Flag [159:128] (lower 32 bit)",
      swaccess: "ro",
      hwaccess: "hrw",
      fields: [
        {bits: "31:0", name: "low", desc: "lower 32 bit"}
      ]
    },
    { name: "FLUSHED_SET2_HIGH",
      desc: "Index-based Flushed Flag [191:160] (upper 32 bit)",
      swaccess: "ro",
      hwaccess: "hrw",
      fields: [
        {bits: "31:0", name: "high", desc: "upper 32 bit"}
      ]
    },
    { name: "FLUSHED_SET3_LOW",
      desc: "Index-based Flushed Flag [223:192] (lower 32 bit)",
      swaccess: "ro",
      hwaccess: "hrw",
      fields: [
        {bits: "31:0", name: "low", desc: "lower 32 bit"}
      ]
    },
    { name: "FLUSHED_SET3_HIGH",
      desc: "Index-based Flushed Flag [255:224] (upper 32 bit)",
      swaccess: "ro",
      hwaccess: "hrw",
      fields: [
        {bits: "31:0", name: "high", desc: "upper 32 bit"}
      ]
    }
  ]
}
