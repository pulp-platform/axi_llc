{ name: "CFG_SET_PARTITION0_LOW",
   desc: "Index-based Partition Configuration [31:0] (lower 32 bit)",
   swaccess: "rw",
   hwaccess: "hrw",
   fields: [
    {bits: "31:0", name: "low", desc: "lower 32 bit"}
   ]
},
{ name: "CFG_SET_PARTITION0_HIGH",
   desc: "Index-based Partition Configuration [63:32] (upper 32 bit)",
   swaccess: "rw",
   hwaccess: "hrw",
   fields: [
    {bits: "31:0", name: "high", desc: "upper 32 bit"}
   ]
},{ name: "CFG_SET_PARTITION1_LOW",
   desc: "Index-based Partition Configuration [31:0] (lower 32 bit)",
   swaccess: "rw",
   hwaccess: "hrw",
   fields: [
    {bits: "31:0", name: "low", desc: "lower 32 bit"}
   ]
},
{ name: "CFG_SET_PARTITION1_HIGH",
   desc: "Index-based Partition Configuration [63:32] (upper 32 bit)",
   swaccess: "rw",
   hwaccess: "hrw",
   fields: [
    {bits: "31:0", name: "high", desc: "upper 32 bit"}
   ]
},{ name: "CFG_SET_PARTITION2_LOW",
   desc: "Index-based Partition Configuration [31:0] (lower 32 bit)",
   swaccess: "rw",
   hwaccess: "hrw",
   fields: [
    {bits: "31:0", name: "low", desc: "lower 32 bit"}
   ]
},
{ name: "CFG_SET_PARTITION2_HIGH",
   desc: "Index-based Partition Configuration [63:32] (upper 32 bit)",
   swaccess: "rw",
   hwaccess: "hrw",
   fields: [
    {bits: "31:0", name: "high", desc: "upper 32 bit"}
   ]
},{ name: "CFG_SET_PARTITION3_LOW",
   desc: "Index-based Partition Configuration [31:0] (lower 32 bit)",
   swaccess: "rw",
   hwaccess: "hrw",
   fields: [
    {bits: "31:0", name: "low", desc: "lower 32 bit"}
   ]
},
{ name: "CFG_SET_PARTITION3_HIGH",
   desc: "Index-based Partition Configuration [63:32] (upper 32 bit)",
   swaccess: "rw",
   hwaccess: "hrw",
   fields: [
    {bits: "31:0", name: "high", desc: "upper 32 bit"}
   ]
},
{ name: "COMMIT_CFG",
  desc: "Commit the configuration",
  swaccess: "rw1s",
  hwaccess: "hrw",
  fields: [
    {bits: "0", name: "commit", desc: "commit configuration"}
  ]
},
{skipto: "0x58"}
{ name: "COMMIT_PARTITION_CFG",
  desc: "Commit the set partition configuration",
  swaccess: "rw1s",
  hwaccess: "hrw",
  fields: [
    {bits: "0", name: "commit", desc: "commit set partition configuration"}
  ]
},
{skipto: "0x60"}